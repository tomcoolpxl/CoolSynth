* Roland TR-808 snare drum, from the service notes (pp. 6, 9; D256), in its changed version (page 9's "portion
* changed": C58 0.056u, C61 0.015u, R191 10k, R200 a link). The reference for the 808 Snare & Clap generator's snare.
* Transistors and the 1S2473 diodes as in the bass drum's netlist, single-pole 3 MHz op-amps (uPC4558) with their
* +-14 V swing on the bridged-Ts, junction capacitances for the solver.
*
* Parameters: amp (TRIG volts, 4 to 14), tone (the TONE knob VR8 0..1, 1 at pin 3: IC14b, the upper shell), snappy
* (the SNAPPY knob VR9 0..1), lev (the LEVEL knob VR7 0..1, a 100k audio pot), rail, cgbw (the op-amps' pole
* capacitor: 53.05p for 3 MHz), wn (the white noise bus: 0 off, else two sines of that amplitude each at fwa and
* fwb, for checking the snappy deterministically), tend, width, tedge; c58, c61, r191, r200 (the changed values;
* the early ones are 27n, 6.8n, 8.2k, 47k).
.param rail=14 amp=4 tone=0.5 snappy=0.5 lev=0.8 wn=0 fwa=1.7k fwb=5.3k tend=0.3 width=1m tedge=5.2u cgbw=53.05p
.param c58=56n c61=15n r191=10k r200=1m
.param base={amp+0.68}
.param vr={max(100k*(pow(10, 2*lev)-1)/99, 1)}
.param vr8a={max(100k*(1-tone), 1)} vr8b={max(100k*tone, 1)}
.param vr9a={max(10k*(1-snappy), 1)} vr9b={max(10k*snappy, 1)}

.model QEM NPN(IS=10f BF=300 BR=4 CJE=8p CJC=4p)
.model QPM PNP(IS=10f BF=300 BR=4 CJE=8p CJC=4p)
.model DEM D(IS=2.52n N=1.752 RS=0.568 CJO=2p)
* The bridged-Ts' op-amps' output swing (uPC4558: +-14 V typical on +-15 V rails): clamp diodes on their inner nodes.
.model DCL D(IS=1e-12 N=1)

VB3 vcc 0 15
VNB3 vee 0 -15

* The trigger, as the bass drum's: Q32 onto the TRIG line, the snare's PNP switch Q46 (R183, R182 through Q45, whose
* base the instrument line drives through R180 with R181).
V6 n6 0 PWL(0 5 {tedge-0.5u} 5 {tedge+0.5u} 0 {tedge+width-0.5u} 0 {tedge+width+0.5u} 5)
R117 n6 nb31 47k
Q31 nb32 nb31 0 QEM
VX nx 0 {base}
R120 nx nb32 4.7k
Q32 vcc nb32 trig QEM
R113 trig 0 4.7k
VSD nsd 0 PWL(0 5 {tedge+width+20u} 5 {tedge+width+21u} 0)
R180 nsd nb45 22k
R181 nb45 0 10k
Q45 nc45 nb45 0 QEM
R183 trig nb46 4.7k
R182 nb46 nc45 10k
Q46 vt nb46 trig QPM

* The pulses into the two bridged-Ts: R189 with C57 across it into IC14a's + input over R190; R191 into IC14b's over
* R192.
R189 vt np1 100k
C57 vt np1 6.8n
R190 np1 0 680
R191 vt np2 {r191}
R192 np2 0 220

* IC14a: a bridged-T, C58 and C59 with R197 820k across and R196 680 to ground (the lower shell).
G1 0 i1 np1 nm1 1m
RI1 i1 0 1e8
CI1 i1 0 {cgbw}
B1 no1 0 V=v(i1)
DCP1 i1 ncp1 DCL
VCP1 ncp1 0 {rail-0.55}
DCN1 ncn1 i1 DCL
VCN1 ncn1 0 {-rail+0.55}
C58 nm1 nmid1 {c58}
C59 nmid1 no1 27n
R197 nm1 no1 820k
R196 nmid1 0 680

* IC14b: a bridged-T, C60 and C61 with R198 1M across and R195 2.2k to ground (the upper shell).
G2 0 i2 np2 nm2 1m
RI2 i2 0 1e8
CI2 i2 0 {cgbw}
B2 no2 0 V=v(i2)
DCP2 i2 ncp2 DCL
VCP2 ncp2 0 {rail-0.55}
DCN2 ncn2 i2 DCL
VCN2 ncn2 0 {-rail+0.55}
C60 nm2 nmid2 6.8n
C61 nmid2 no2 {c61}
R198 nm2 no2 1Meg
R195 nmid2 0 2.2k

* The TONE pot VR8 (100k B) between the two shells: C63 from IC14a to pin 1, R200 and C65 from IC14b to pin 3; its
* wiper through R204 into IC13.
C63 no1 nv1 47n
R200 no2 n200 {r200}
C65 n200 nv3 47n
RV8A nv3 nw8 {vr8a}
RV8B nw8 nv1 {vr8b}
R204 nw8 nsum 100k

* The snappy's envelope: the trigger through the SNAPPY pot VR9 (10k B, R199 below it) and R186 into Q47's base;
* Q47 (its collector supplied through R187 from C55 and R193) charges C51, given up through R184, C52 and R185 to
* D54 and the swing VCA Q48.
RV9A vt nw9 {vr9a}
RV9B nw9 n199 {vr9b}
R199 n199 0 1k
R186 nw9 nb47 33k
R193 vcc n55 100
C55 n55 0 47u
R187 n55 nc47 330
Q47 nc47 nb47 ne47 QEM
C51 ne47 0 0.47u
R184 ne47 n52 15k
C52 n52 0 0.1u
R185 n52 nsn 15k
C53 nsn 0 1n

* Q48, the swing VCA: the white noise through C56 into its base (R194 2.2M from the supply), R188 in its emitter,
* its collector fed from the envelope through D54, C54 across it.
VWA nwn nwb SIN(0 {wn} {fwa})
VWB nwb 0 SIN(0 {wn} {fwb})
C56 nwn nb48 22n
R194 vcc nb48 2.2Meg
Q48 nc48 nb48 ne48 QEM
R188 ne48 0 100
D54 nsn nc48 DEM
C54 nc48 0 2.7n

* Q49: a high-pass from the envelope's node (C66, C67 1.8n, R201 22k back from the follower's emitter, R202 47k), R203
* to the negative supply; through C69 and R205 into IC13.
C66 nsn nm49 1.8n
C67 nm49 nb49 1.8n
R201 nm49 ne49 22k
R202 nb49 0 47k
Q49 vcc nb49 ne49 QEM
R203 ne49 vee 22k
C69 ne49 n69 10n
R205 n69 nsum 27k

* IC13: the mixer, R210 470k, C70 220p and the LEVEL pot (100k A) with C68 in its feedback; R206 to its + input.
G13 0 i13 0 nsum 1m
RI13 i13 0 1e8
CI13 i13 0 {cgbw}
B13 vout 0 V=v(i13)
R210 nsum vout 470k
C70 nsum vout 220p
RVR7 nsum nvr {vr}
C68 nvr vout 33u

.options method=trap reltol=1e-5 abstol=1e-12 vntol=1e-7
.tran 0.5u {tend} 0 0.5u
.end
