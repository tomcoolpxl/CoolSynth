* Roland TR-808 rim shot / claves, from the service notes (pp. 6, 9; D252). The reference for the 808 Drums
* generator's rim shot and claves circuit. Transistors and the 1S2473 diodes as in the bass drum's netlist,
* single-pole 3 MHz op-amps (uPC4558), junction capacitances for the solver.
*
* Parameters: amp (TRIG volts, 4 to 14), rs (1 rim shot, 0 claves: SW11), lev (the LEVEL knob 0..1, a 100k audio pot),
* rail (the resonators' op-amps' output swing, volts),
* r324 (R324, unprinted in the service notes: 130k, fitted to both units' rim shot over their claves; one builder reads
* 220k), r313 (printed 390k, with which the claves ring on: 500k, fitted to both units' 24 ms), tend, width, tedge,
* cgbw (the op-amps' pole capacitor: 53.05p for 3 MHz).
.param rail=14 amp=4 rs=1 lev=0.8 r324=130k tend=0.3 width=1m tedge=5.2u cgbw=53.05p r313=500k
.param base={amp+0.68}
.param vr={max(100k*(pow(10, 2*lev)-1)/99, 1)}
.param c118on={rs > 0.5 ? 2.2n : 1p} r313on={rs > 0.5 ? 1G : r313}
.param r324on={rs > 0.5 ? r324 : 1G} r319on={rs > 0.5 ? 1G : 220k}

.model QEM NPN(IS=10f BF=300 BR=4 CJE=8p CJC=4p)
.model QPM PNP(IS=10f BF=300 BR=4 CJE=8p CJC=4p)
.model DEM D(IS=2.52n N=1.752 RS=0.568 CJO=2p)
* The resonators' op-amps' output swing (uPC4558: +-14 V typical on +-15 V rails): clamp diodes on their inner nodes.
.model DCL D(IS=1e-12 N=1)

VB7 vcc 0 15
VNB7 vee 0 -15

* The trigger, as the bass drum's: Q32 onto the TRIG line, the voice's PNP switch Q60 (R299, R298 through Q59), and
* R300 as its load.
V6 n6 0 PWL(0 5 {tedge-0.5u} 5 {tedge+0.5u} 0 {tedge+width-0.5u} 0 {tedge+width+0.5u} 5)
R117 n6 nb31 47k
Q31 nb32 nb31 0 QEM
VX nx 0 {base}
R120 nx nb32 4.7k
Q32 vcc nb32 trig QEM
R113 trig 0 4.7k
VRS nrs 0 PWL(0 5 {tedge+width+20u} 5 {tedge+width+21u} 0)
R297 nrs nb59 22k
R303 nb59 0 10k
Q59 nc59 nb59 0 QEM
R299 trig nb60 4.7k
R298 nb60 nc59 10k
Q60 vt nb60 trig QPM
R300 vt 0 22k

* The two resonators' pulses: C111, R307, D62, R301 into IC21 with R302; C114, R306, D64, R310 into IC20a with R311.
C111 vt na21 10n
R307 na21 0 100k
D62 na21 nb21 DEM
R301 nb21 np21 47k
R302 np21 0 10k
C114 vt na20 1n
R306 na20 0 22k
D64 na20 nb20 DEM
R310 nb20 np20 33k
R311 np20 0 10k

* IC21: a bridged-T, C116 and C115 4.7n with R316 1M across and R315 5.6k to ground (about 455 Hz).
G21 0 i21 np21 ninv21 1m
RI21 i21 0 1e8
CI21 i21 0 {cgbw}
B21 no21 0 V=v(i21)
DCP21 i21 ncp21 DCL
VCP21 ncp21 0 {rail-0.55}
DCN21 ncn21 i21 DCL
VCN21 ncn21 0 {-rail+0.55}
C116 ninv21 nm21 4.7n
C115 nm21 no21 4.7n
R316 ninv21 no21 1Meg
R315 nm21 0 5.6k

* IC20a: a bridged-T, C119 and C117 2.2n with R308 820k across and R312 1k to ground (about 2.5 kHz); for the rim
* shot SW11 puts C118 across C117 (about 1.8 kHz), for the claves R313 from the middle node to IC20b's output.
* R312 (printed 1k) 1.07k, fitted to both units' rim shot and claves pitch, some 3 % sharp as printed (D258).
G20A 0 i20a np20 ninv20 1m
RI20A i20a 0 1e8
CI20A i20a 0 {cgbw}
B20A no20a 0 V=v(i20a)
C119 ninv20 nm20 2.2n
C117 nm20 no20a 2.2n
C118 nm20 no20a {c118on}
R308 ninv20 no20a 820k
R312 nm20 0 1.07k
R313 nm20 no20b {r313on}

* IC20b inverts (R314, R309 33k).
R314 no20a nin20b 33k
R309 nin20b no20b 33k
G20B 0 i20b 0 nin20b 1m
RI20B i20b 0 1e8
CI20B i20b 0 {cgbw}
B20B no20b 0 V=v(i20b)
DCP20A i20a ncp20A DCL
VCP20A ncp20A 0 {rail-0.55}
DCN20A ncn20A i20a DCL
VCN20A ncn20A 0 {-rail+0.55}
DCP20B i20b ncp20B DCL
VCP20B ncp20B 0 {rail-0.55}
DCN20B ncn20B i20b DCL
VCN20B ncn20B 0 {-rail+0.55}

* Q62, the swing VCA: IC21 through R318 and IC20b through R320 onto R317, through C120 into Q62's base (R321 2.2M from
* the supply); its collector supplied by the envelope, which C24 takes from the trigger through D61 and R107 and gives
* up through R108 and D63.
R318 no21 ns 220k
R320 no20b ns 22k
R317 ns 0 10k
C120 ns nb62 10u
R321 vcc nb62 2.2Meg
D61 vt n61 DEM
R107 n61 nenv 1k
C24 nenv 0 0.47u
R108 nenv n108 10k
D63 n108 nf DEM
Q62 nf nb62 0 QEM

* Q63: a high-pass from Q62's collector (C121, C122 4.7n, R322 10k back from the follower's emitter, R325 330k).
C121 nf ng 4.7n
C122 ng nb63 4.7n
R325 nb63 0 330k
R322 ng ne63 10k
Q63 vcc nb63 ne63 QEM
R323 ne63 vee 22k

* IC19: the rim shot from Q63 through R324, or the claves from IC20b through R319; C125 and R326 into its minus
* input, R330 470k, C153 22p and the LEVEL pot (100k A) with C126 33u across it.
R324 ne63 nsw {r324on}
R319 no20b nsw {r319on}
C125 nsw nc125 10n
R326 nc125 nsum 10k
G19 0 i19 0 nsum 1m
RI19 i19 0 1e8
CI19 i19 0 {cgbw}
B19 vout 0 V=v(i19)
R330 nsum vout 470k
C153 nsum vout 22p
RVR16 nsum nvr {vr}
C126 nvr vout 33u

.options method=trap reltol=1e-5 abstol=1e-12 vntol=1e-7
.tran 0.5u {tend} 0 0.5u
.end
