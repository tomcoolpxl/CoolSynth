* Roland TR-808 bass drum, after Werner's 2016 thesis (Figure II, Tables 1.1, 3.1, 4.1, 4.2).
* The reference for the Kick generator's 808 circuit model (D235): run with tools/kick808/render.py.
* Op-amps ideal (very high gain), as the thesis's nullors; transistors and diodes as the thesis's models.
*
* Parameters (set by render.py): amp (trigger volts, 4 unaccented to 14), dec (decay 0..1), tone (0..1),
* lev (level 0..1), tend (seconds to simulate).
.param amp=4 dec=0.4 tone=0.99 lev=0.99 tend=0.6
.param edge={4/44100}
.param vr6={max(dec*500k,1)}
.param vr5={max((1-tone)*10k,1)}
.param vr4top={max((1-lev)*100k,1)} vr4bot={max(lev*100k,1)}

.model QEM NPN(IS=10f BF=300 BR=4)
.model DEM D(IS=2.52n N=1)

VB2 vcc 0 15
VNB2 vee 0 -15
* The trigger: a 1 ms pulse whose edges ramp over 4/44100 s (the thesis's conclusion).
VIN vin 0 PWL(0 0 {edge} {amp} 1m {amp} {1m+edge} 0)

* Pulse shaper
C40 vin npulse 0.015u
R163 vin npulse 100k
R162 npulse 0 4.7k
D53 0 npulse DEM

* Envelope generator
R157 vin nb41 8.2k
R158 nb41 0 2.7k
Q41 nc41 nb41 0 QEM
R156 vcc nc41 1Meg
C38 nc41 0 0.1u
Q42 neg nc41 0 QEM
R160 vcc neg 22k

* Retrigger network and the attack transistor
C39 neg nd52 0.033u
D52 nd52 0 DEM
R161 nd52 ntop 1Meg
R159 neg nb43 100k
Q43 nmid nb43 0 QEM
R166 ntop nmid 6.8k
R165 nmid 0 47k

* Bridged-T around the first op-amp
C41 ntop ninv 0.015u
C42 ntop nout 0.015u
R167 ninv nout 1Meg
EOP1 nout 0 npulse ninv 1e7
RL nout 0 1Meg

* Feedback buffer
R164 nout ninv2 47k
RVR6 ninv2 nvr6 {vr6}
C43 nvr6 nfb 33u
R169 ninv2 nfb 47k
R168 nplus2 0 22k
EOP2 nfb 0 nplus2 ninv2 1e7
R170 nfb ntop 470k

* Output filter: tone (VR5 with R172), level (VR4), the emitter follower Q44
R171 nout na 220
R172 na nb 10k
RVR5 na nb {vr5}
C45 nb 0 0.1u
C47 nb nc 0.47u
RVR4T nc nw {vr4top}
RVR4B nw 0 {vr4bot}
C49 nw nd 0.47u
R177 nd nb44 82k
R176 nb44 0 100k
Q44 vcc nb44 ne44 QEM
R173 ne44 vee 6.8k
C48 ne44 0 220p
C50 ne44 vout 1u
R174 vout 0 100k

.options method=trap reltol=1e-5 abstol=1e-12 vntol=1e-7
.tran 0.5u {tend} 0 1.417u
.end
