* Roland TR-808 bass drum, after Werner's 2016 thesis (Figure II, Tables 1.1, 3.1, 4.1, 4.2) and the service notes.
* The reference for the Kick generator's 808 circuit model (D235, D251): run with tools/kick808/render.py.
* Transistors as the thesis's 2N3904 stand-in for the 2SC945(P) (and a PNP like it for the 2SA733(P)), diodes as the
* standard 1N4148 model for the 1S2473 (D251: the thesis keeps its Is but not its emission coefficient). The junction
* capacitances are only there so the solver passes the trigger's edges; they act in the megahertz.
* The op-amps (uPC4558) are single-pole, 1e5 at DC and 3 MHz gain-bandwidth: an ideal one cannot pass a sharp edge.
*
* Parameters (set by render.py): amp (trigger volts on the TRIG line, 4 unaccented to 14), dec (decay 0..1.48),
* tone (0..1), lev (level 0..1), tend (seconds to simulate), width (the trigger pulse), glide (the glide bend's
* size, 0 for none), c39s and c38s (C39 and C38 scaled), tedge (when the trigger rises: half a sample in, where
* the model's step falls, as the trapezoidal rule takes a step between two samples as a ramp across them).
.param amp=4 dec=0.4 tone=0.99 lev=0.99 tend=0.6
.param width=1m glide=0 c39s=1 c38s=1 tedge=5.2u
.param vr6={max(dec*500k,1)}
.param vr5={max((1-tone)*10k,1)}
.param vr4top={max((1-lev)*100k,1)} vr4bot={max(lev*100k,1)}
.param base={amp+0.68}

.model QEM NPN(IS=10f BF=300 BR=4 CJE=8p CJC=4p)
.model QPM PNP(IS=10f BF=300 BR=4 CJE=8p CJC=4p)
.model DEM D(IS=2.52n N=1.752 RS=0.568 CJO=2p)

VB2 vcc 0 15
VNB2 vee 0 -15

* The trigger (service notes pp. 4, 8, 9): IC6's 1 ms pulse turns Q31 off, so Q32's base rises to about 5 V
* (unaccented, Q34 shunting VR3) or to VR3's 5 to 15 V (accented), and Q32 follows it onto the TRIG line, which
* R113 holds down when Q32 lets go. The bass drum's Q39 is on while its instrument data stands (until just after the
* pulse) and switches Q40, a PNP that can only push current, onto the drum.
V6 n6 0 PWL(0 5 {tedge-0.5u} 5 {tedge+0.5u} 0 {tedge+width-0.5u} 0 {tedge+width+0.5u} 5)
R117 n6 nb31 47k
Q31 nb32 nb31 0 QEM
VX nx 0 {base}
R120 nx nb32 4.7k
Q32 vcc nb32 trig QEM
R113 trig 0 4.7k
VBD nbd 0 PWL(0 5 {tedge+width+20u} 5 {tedge+width+21u} 0)
R152 nbd nb39 22k
R153 nb39 0 10k
Q39 nc39 nb39 0 QEM
R155 trig nb40 4.7k
R154 nb40 nc39 10k
Q40 vin nb40 trig QPM

* Pulse shaper
C40 vin npulse 0.015u
R163 vin npulse 100k
R162 npulse 0 4.7k
D53 0 npulse DEM

* Envelope generator
R157 vin nb41 8.2k
R158 nb41 0 2.7k
Q41 nc41 nb41 0 QEM
R156 vcc nc41 1Meg
C38 nc41 0 {0.1u*c38s}
Q42 neg nc41 0 QEM
R160 vcc neg 22k

* Retrigger network and the attack transistor
C39 neg nd52 {0.033u*c39s}
D52 nd52 0 DEM
R161 nd52 ntop 1Meg
R159 neg nb43 100k
Q43 nmid nb43 0 QEM
R166 ntop nmid 6.8k
R165 nmid 0 47k

* The glide bend (Punch Time past 6 ms, D251): a second transistor across R165, its base capacitor charged by the
* trigger pulse through a diode and 4.7k and drained through 100k, so it lets go of R165 gradually.
* With glide 0 the bend is out, as on a real 808: its transistor's collector through 1 GOhm.
RQ nmid nqg {glide > 0 ? 1 : 1G}
QG nqg nbg 0 QEM
DG vin ndg DEM
RG ndg nbg {glide > 0 ? 4.7k/glide : 1G}
CG nbg 0 {0.47u*max(glide, 1m)}
RB nbg 0 1Meg

* Bridged-T around the first op-amp
C41 ntop ninv 0.015u
C42 ntop nout 0.015u
R167 ninv nout 1Meg
G1 0 i1 npulse ninv 1m
RI1 i1 0 1e8
CI1 i1 0 53.05p
B1 nout 0 V=v(i1)
RL nout 0 1Meg

* Feedback buffer
R164 nout ninv2 47k
RVR6 ninv2 nvr6 {vr6}
C43 nvr6 nfb 33u
R169 ninv2 nfb 47k
R168 nplus2 0 22k
G2 0 i2 nplus2 ninv2 1m
RI2 i2 0 1e8
CI2 i2 0 53.05p
B2 nfb 0 V=v(i2)
R170 nfb ntop 470k

* Output filter: tone (VR5 with R172), level (VR4), the emitter follower Q44
R171 nout na 220
R172 na nb 10k
RVR5 na nb {vr5}
C45 nb 0 0.1u
C47 nb nc 0.47u
RVR4T nc nw {vr4top}
RVR4B nw 0 {vr4bot}
C49 nw nd 0.47u
R177 nd nb44 82k
R176 nb44 0 100k
Q44 vcc nb44 ne44 QEM
R173 ne44 vee 6.8k
C48 ne44 0 220p
C50 ne44 vout 1u
R174 vout 0 100k

.options method=trap reltol=1e-5 abstol=1e-12 vntol=1e-7
.tran 0.5u {tend} 0 0.5u
.end
