* Roland TR-909 bass drum, read from the service notes' voicing board (page 11), units from S/N 381500 (C9 0.33 uF).
* The reference for the Kick generator's 909 circuit model (D237): run with tools/kick909/render.py, which sets the
* parameters, the time step and the op-amp model (OPAMP: TI's RC4558 macromodel, or an ideal one).
* Transistors (2SC2603, 2SA1115) and diodes (1SS133) as generic Ebers-Moll and Shockley models, as in the C++ model.
*
* Parameters (set by render.py): vdac (the accent DAC, 0..5 V), vr2 (TUNE), vr5 (DECAY), vr3 (ATTACK), vr4 (LEVEL),
* all rheostats in ohms; ttrig (the trigger's start), tend (seconds to simulate).
.param vdac=2.5 vr2=50k vr5=500k vr3=250 vr4=50k ttrig=5m tend=0.6

.model QN NPN(IS=10f BF=300 BR=5)
.model QP PNP(IS=10f BF=250 BR=5)
.model DS D(IS=2.52n N=1.752)

VCC vcc 0 15
VEE vee 0 -15
* The sequencer's trigger: 5 V for 2 ms from the 4174 latch.
VTRIG trig 0 PULSE(0 5 {ttrig} 1u 1u 2m 10)
* The accent DAC (6-bit, 0..5 V), held.
VDAC dac 0 {vdac}
* The noise bus: 0/15 V bits; their mean only, for references (C15 blocks it).
VNZ nz 0 7.5

* Q1: the trigger switch
R1 trig b1 22k
R2 b1 0 10k
Q1 n1 b1 0 QN
* Q2: the unaccented +15 V pulse, at n4
R4 vcc n2 47k
R3 n2 n3 100k
D4 n3 n1 DS
R11 n3 n11 4.7k
C6 n11 0 2.2n
Q2 n4 n2 vcc QP
R19 n4 0 2.2k
* Q7: the edge of the trigger, through C1, resets the oscillator (Q11) and forces its comparator (D12)
R13 vcc n7b 47k
R12 n7b n12 100k
C1 n12 n1 68n
Q7 n7c n7b vcc QP
R47 n7c q11b 330k
R48 n7c n48 22k
D12 n48 nx DS
* IC11b: the accent buffer, x3.13
XU11B dac i11b vcc vee acc OPAMP
R37 acc i11b 10k
R38 i11b 0 4.7k
* Q5: the accent, gated by the trigger, into ENV2 (C12) for the attack's VCA Q6
R39 acc q5b 1meg
R34 q5b n34 100k
D5 n34 n1 DS
Q5 n5c q5b acc QP
R41 n5c c12 22k
C12 c12 0 33n
R42 c12 q6b 470k
* R495 (printed "SN up to 371499 surface mounted"): from Q6's base to ground
R495 q6b 0 150k
* The hold: C7 from the pulse, through R18 into Q3, which keeps Q4 passing the accent
D6 n4 n6 DS
R20 n6 c7 6.8k
C7 c7 0 33n
R18 c7 q3b 470k
R17 q3b 0 470k
Q3 n32 q3b 0 QN
R32 n32 q4b 47k
R33 acc q4b 1meg
Q4 e1 q4b acc QP
* ENV1: C8, charged through R35 and D9, clamped by D8 at the R36/R22 divider, decaying through DECAY
R35 e1 nk 1.8k
D9 nk c8 DS
D8 nk ny DS
R36 vcc ny 47k
R22 ny 0 10k
C8 c8 0 0.33u
RVR5 c8 n58 {vr5}
R58 n58 0 47k
R54 c8 q12b 470k
* ENV3: the pitch envelope on C9; TUNE sets how fast it falls
D7 n4 n7a DS
R21 n7a c9 2.2k
C9 c9 0 0.33u
R57 c9 n57 22k
RVR2 n57 0 {vr2}
* IC12a: the control voltage, -(1.5 V + 0.4545 V(C9))
R26 c9 i12a 330k
R27 vcc i12a 1.5meg
R28 i12a cv 150k
R25 p12a 0 100k
XU12A p12a i12a vcc vee cv OPAMP
* IC12b: plus or minus the control voltage, as the PNP Q10 (the comparator's) says
R29 cv i12b 100k
R30 i12b sq 100k
R31 cv p12b 100k
XU12B p12b i12b vcc vee sq OPAMP
Q10 p12b q10b 0 QP
R23 cmp q10b 100k
R24 q10b 0 22k
* IC13a: the integrator; Q11 shorts C14 through R51 at the trigger
R59 sq i13a 47k
C14 i13a tri 33n
XU13A 0 i13a vcc vee tri OPAMP
Q11 n51 q11b i13a QN
R51 n51 tri 2.2k
* IC13b: the comparator with hysteresis (R49, R50)
XU13B nx tri vcc vee cmp OPAMP
R49 cmp nx 100k
* R50 printed 47k; fitted to 60k (D240): a triangle near 4.9 V gives the real units' 49.5 Hz and harmonics
R50 nx 0 60k
* The shaper (D10, D11) and the VCA Q12, its emitter on the mixer's virtual ground
R52 tri nd 10k
D10 nd 0 DS
D11 0 nd DS
R53 nd nvca 2.2k
R43 nvca 0 47
Q12 nvca q12b sum QN
* The click: Q8 lets C5 fall while the pulse lasts and snaps it back at its end; the Sallen-Key low-pass around Q9
* passes the edges. R8 returns to -15 V, as operator reads it
* (D238): the service notes print it to Q4's collector (e1), which two real 909s' recordings contradict
R6 vcc q8b 22k
R5 n4 q8b 100k
* Q8 a PNP switch (D240): on at rest, holding C5 near +15 V; off while the pulse lifts its base
Q8 q8e q8b vcc QP
C5 q8e 0 6.8n
R14 q8e 0 22k
C2 q8e n2c 3.3n
R7 n2c s1 100k
R15 s1 0 100k
R16 s1 s2 39k
C4 s2 0 100p
C3 s1 q9e 4.7n
Q9 vcc s2 q9e QN
R8 q9e vee 10k
C11 q9e n11c 0.47u
R44 n11c a1 22k
* The noise: divided, high-passed (C15), low-passed (R46, C13)
R10 nz n10 12k
R9 n10 0 4.7k
C15 n10 n15 0.47u
R46 n15 n13 4.7k
C13 n13 0 0.1u
R45 n13 a1 4.7k
R56 a1 0 330
* ATTACK and the attack's VCA Q6
RVR3 a1 a2 {vr3}
R55 a2 0 47
Q6 a2 q6b sum QN
* IC11a: the mixer; LEVEL is its feedback
XU11A 0 sum vcc vee out OPAMP
RVR4 sum out {vr4}

.tran 10u {tend} 0 10u
.end
